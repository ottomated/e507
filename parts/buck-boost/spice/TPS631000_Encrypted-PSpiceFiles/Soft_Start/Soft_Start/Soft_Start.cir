** Profile: "Soft_Start-Soft_Start"  [ C:\Users\a0488911\Desktop\Humberg\TPS631000_Encrypted\TPS631000_Encrypted-PSpiceFiles\Soft_Start\Soft_Start.sim ]

** Creating circuit file "Soft_Start.cir"
** WARNING: THIS AUTOMATICALLY GENERATED FILE MAY BE OVERWRITTEN BY SUBSEQUENT SIMULATIONS

*Libraries:
* Profile Libraries :
* Local Libraries :
.LIB "../../../tps631000.lib"
.LIB "../../../generic_blocks.lib"
* From [PSPICE NETLIST] section of C:\SPB_Data\cdssetup\OrCAD_PSpice\17.4.0\PSpice.ini file:
.lib "nom.lib"

*Analysis directives:
.TRAN  0 0.6m 0 10n SKIPBP
.OPTIONS ADVCONV
.AUTOCONVERGE ITL1=1000 ITL2=1000 ITL4=1000 RELTOL=0.05 ABSTOL=1.0E-6 VNTOL=.001 PIVTOL=1.0E-10
.PROBE64 V(alias(*)) I(alias(*))
.INC "..\Soft_Start.net"

.END
