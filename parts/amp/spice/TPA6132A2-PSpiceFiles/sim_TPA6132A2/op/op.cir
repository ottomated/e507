** Profile: "sim_TPA6132A2-op"  [ C:\Documents and Settings\a0217140\Desktop\New Folder\tpa6132a2-pspicefiles\sim_tpa6132a2\op.sim ]

** Creating circuit file "op.cir"
** WARNING: THIS AUTOMATICALLY GENERATED FILE MAY BE OVERWRITTEN BY SUBSEQUENT SIMULATIONS

*Libraries:
* Profile Libraries :
* Local Libraries :
.LIB "../../../tpa6132a2.lib"
* From [PSPICE NETLIST] section of C:\Cadence\SPB_16.2\tools\PSpice\PSpice.ini file:
.lib "nom.lib"

*Analysis directives:
.OPTIONS STEPGMIN
.OPTIONS PREORDER
.AUTOCONVERGE ITL1=1000 ITL2=1000 ITL4=1000 RELTOL=0.05 ABSTOL=1.0E-6 VNTOL=.001 PIVTOL=1.0E-10
.PROBE V(alias(*)) I(alias(*)) W(alias(*)) D(alias(*)) NOISE(alias(*))
.INC "..\sim_TPA6132A2.net"

.END
